* Harness box v3, nominal, pass-through. Generated by box_model.py; do not edit by hand.
* Hand-transcribed from comma.ai Harness_Box.pdf v3 (commaai/hardware 530b7da; RR-2026-010 section 2).
* Node citations (wire-end IDs of ../wiring/wire-ends.tsv, or the wiring README section 3 row):
*   can0h    CAN0_H car (U1 NC, J3 A2)  [HB.U1.2-J3.A2]
*   can0l    CAN0_L car (U2 COM, J3 A3)  [HB.U2.1-J3.A3]
*   can2h    CAN2_H camera (U1 COM, J3 B2)  [HB.U1.1-J3.B2]
*   can2l    CAN2_L camera (U2 NC, J3 B3)  [HB.U2.2-J3.B3]
*   can2hp   CAN2_H' (U1 NO, R7/R8)  [README 3: R7]
*   can0lp   CAN0_L' (U2 NO, R6)  [README 3: R6]
*   can2lpp  CAN2_L'' (J1 P15, R8)  [README 3: R8]
*   vin      VIN (box supply, U1/U2 V+ and VL)  [HB.D1.K-J3.A4]
*   sbu1     SBU1 (U1/U2 IN, R2/R3)  [HB.R2/R3.1-J3.A8]
.model dsch d(is=1e-8 n=1.05 rs=1 cjo=5p) ; generic small-signal Schottky, not the BAS40SDW vendor model
* U1 on CAN_H: COM = CAN2_H camera, NC = CAN0_H car, NO = CAN2_H' (idealised: R_on or R_off)
RU1NC can2h can0h 30
RU1NO can2h can2hp 1e+09
* U2 on CAN_L: COM = CAN0_L car, NC = CAN2_L camera, NO = CAN0_L'
RU2NC can0l can2l 30
RU2NO can0l can0lp 1e+09
* terminations on the NO side; Toyota A loops J1 P13-P15 (CAN2_L to CAN2_L''), not P3-P5
R7 can2l can2hp 120
R8 can2lpp can2hp 120
RLOOP can2l can2lpp 1m
R6 can0lp can0hpp 120
RHPP can0hpp 0 1e9
* supply
VVIN vin 0 13.2
Dcan0hUP can0h vin dsch
Dcan0hDN 0 can0h dsch
Dcan0lUP can0l vin dsch
Dcan0lDN 0 can0l dsch
Dcan2hUP can2h vin dsch
Dcan2hDN 0 can2h dsch
Dcan2lUP can2l vin dsch
Dcan2lDN 0 can2l dsch
.end
